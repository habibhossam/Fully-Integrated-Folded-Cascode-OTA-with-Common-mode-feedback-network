ADE simulation setup
Run mode: Single Run, Sweeps and Corners
Tests:
  CND_Analog_final:Folded_tb_cl:1: CND_Analog_final/Folded_tb_cl/schematic, simulator spectre
    Outputs: ymax(mag(v("/VOCM" ?result "ac"))); LoopGain_dB
Global variables:
  CL = 1p
  IREF = 20u
  VCN = 750m
  VCP = 550m
  VDD = 1.2
  VICM = 0
  VICMAC = 0
  VID = 0
  VIDAC = 1
  VREF = 600m
