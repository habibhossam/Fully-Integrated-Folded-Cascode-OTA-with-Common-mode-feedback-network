ADE simulation setup
Run mode: Single Run, Sweeps and Corners
Tests:
  CND_Analog_final:Folded_tb:1: CND_Analog_final/Folded_tb/schematic, simulator spectre
Global variables:
  CL = 1p
  IREF = 20u
  VCN = 750m
  VCP = 550m
  VDD = 1.2
  VICM = 300m
  VICMAC = 0
  VID = 0
  VIDAC = 1
  VREF = 600m
Specs:
  CND_Analog_final:Folded_tb:1 / Icnfb: min 40u
  CND_Analog_final:Folded_tb:1 / Iota: min 80u
  CND_Analog_final:Folded_tb:1 / VOUTP: max 600m
  CND_Analog_final:Folded_tb:1 / VOUTN: max 600m
  CND_Analog_final:Folded_tb:1 / UGF: max 20M
  CND_Analog_final:Folded_tb:1 / GBW: max 20M
  CND_Analog_final:Folded_tb:1 / BW: max 32k
  CND_Analog_final:Folded_tb:1 / Av_dB: max 56
  CND_Analog_final:Folded_tb:1 / Av: max 630
