ADE simulation setup
Run mode: Single Run, Sweeps and Corners
Tests:
  CND_Analog_mid:N_Charts:1: CND_Analog_mid/N_Charts/schematic, simulator spectre
Global variables:
  Ln = 60n:20n:2u
  VDS = 1.2
  VGS = 400m
  Wn = 10u
