ADE simulation setup
Run mode: Single Run, Sweeps and Corners
Tests:
  CND_Analog_mid:P_Charts:1: CND_Analog_mid/P_Charts/schematic, simulator spectre
Global variables:
  Lp = 60n:20n:2u
  VSD = 1.2
  VSG = 400m
  Wp = 10u
